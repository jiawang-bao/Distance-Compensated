# Ansys Electronics Desktop project, version 2023.1
materials:
  vacuum: permittivity=1
  Rogers 4450F: permittivity=3.52 dielectric_loss_tangent=0.004
  Rogers RT/duroid 5880 (tm): permittivity=2.2 dielectric_loss_tangent=0.0009
  copper: permeability=0.999991 conductivity=58000000
  pec: conductivity=1e+30
  Teflon(changed): permittivity=1.95 dielectric_loss_tangent=0.02

design SIW-Slot-Array-32-ELC1 (HFSS, HFSS Modal Network, model units mm)
options: Allow_Material_Override Save_Adaptive_support_files
variables:
  Sub_L_phase_shift = 25mm
  Cop_H = 0.035mm
  Sub_W = Array_d*32+20mm
  Sub_H = 0.508mm
  Bond_H = 0.2mm
  SIW_R = 0.15mm
  SIW_W = 3.6mm
  SIW_D = 0.45mm
  num = 16
  match_x = 1.8mm
  match_y = 0.746mm
  slot_y = 0.35mm
  slot_x = 0.4mm
  slot_width = 0.4mm
  slot_length = 4.5mm
  Array_d = 4.3mm
  kz_SIW = 568.39784
  delay_phase_1 = -0.89407374
  delay_length_1 = delay_phase_1/kz_SIW/2*1000mm
  delay_phase_2 = -2.5026715
  delay_phase_3 = 2.0313013
  delay_phase_4 = 0.46215681
  delay_phase_5 = -1.195207
  delay_phase_6 = -2.6557483
  delay_phase_7 = 2.1464766
  delay_phase_8 = 0.8588792
  delay_phase_9 = -1.4879831
  delay_phase_10 = -2.1673691
  delay_phase_11 = 0.5243227
  delay_phase_12 = -0.47994582
  delay_phase_13 = -1
  delay_length_13 = delay_phase_13/kz_SIW/2*1000mm
  delay_phase_14 = p1  # -2/253.6
  delay_length_14 = delay_phase_14/kz_SIW/2*1000mm
  delay_phase_15 = p2  # -1.7/247.6
  delay_length_15 = delay_phase_15/kz_SIW/2*1000mm
  delay_phase_16 = p3  # -0.23/323
  delay_length_16 = delay_phase_16/kz_SIW/2*1000mm
  delay_phase_17 = p4  # 0.6/346
  delay_length_17 = delay_phase_17/kz_SIW/2*1000mm
  delay_phase_18 = p5  # 0.95/25.9
  delay_length_18 = delay_phase_18/kz_SIW/2*1000mm
  delay_phase_19 = p6  # 2.24/96.88
  delay_length_19 = delay_phase_19/kz_SIW/2*1000mm
  delay_phase_20 = p7  # 1.43/113.78
  delay_length_20 = delay_phase_20/kz_SIW/2*1000mm
  delay_phase_21 = -0.47994582
  delay_phase_22 = 0.5243227
  delay_phase_23 = -2.1673691
  delay_phase_24 = -1.4879831
  delay_phase_25 = 0.8588792
  delay_phase_26 = 2.1464766
  delay_phase_27 = -2.6557483
  delay_phase_28 = -1.195207
  delay_phase_29 = 0.46215681
  delay_phase_30 = 2.0313013
  delay_phase_31 = -2.5026715
  delay_phase_32 = -0.89407374
  # PD_para
  Ax4 = 0.015mm
  Ay4_2 = a1
  Bx4 = 1.543mm
  By4 = 1.406mm
  Ax5 = -0.127mm
  Ay5_3 = a2
  Ay5_4 = a3
  Bx5 = 1.705mm
  By5 = 1.191mm
  Ax6 = -0.35mm
  Ay6_5 = a4
  Ay6_6 = a5
  Ay6_7 = a6
  Ay6_8 = a7
  SIW_D2 = 0.5375mm
  By6 = 0.52mm
  Bx6 = 1mm
  # Unit_para
  Feed_W = 1mm
  Trans_slotL = 1.2mm
  gapw = 0.2mm
  Trans_W = 1.2mm
  Trans_W2 = 3mm
  Trans_slotw = 0.2mm
  Feed_L = 1.6mm+2.5mm
  Trans_L = 4mm
  ELC_Sub_H = 2*Sub_H+4*Cop_H+Bond_H
  ELC_Sub_L = 10mm
  p1 = -1.19
  p2 = -2.47
  p3 = -2.8
  p4 = 2.64
  p5 = 1.45
  p6 = 0.94
  p7 = -3.28
  a1 = 0.12mm
  a2 = -0.25mm
  a3 = 0.51mm
  a4 = 0.04mm
  a5 = -0.42mm
  a6 = 0.23mm
  a7 = -0.29mm
geometry:
  GND1 [copper] = box(corner=(-Sub_L_phase_shift, -Sub_W/2, 0mm), size=(101mm, Sub_W, -Cop_H))
  Sub [Rogers RT/duroid 5880 (tm)] = box(corner=(-Sub_L_phase_shift, -Sub_W/2, 0mm), size=(101mm, Sub_W, Sub_H))
  GND2 [copper] = box(corner=(-Sub_L_phase_shift, -Sub_W/2, Sub_H), size=(101mm, Sub_W, Cop_H))
  Bond_layer [Rogers 4450F] = box(corner=(-Sub_L_phase_shift, -Sub_W/2, Sub_H+Cop_H), size=(101mm, Sub_W, Bond_H))
  Sub1 [Rogers RT/duroid 5880 (tm)] = box(corner=(-Sub_L_phase_shift, -Sub_W/2, Sub_H+Cop_H*2+Bond_H), size=(101mm, Sub_W, Sub_H))
  GND3 [copper] = box(corner=(-Sub_L_phase_shift, -Sub_W/2, Sub_H+Cop_H+Bond_H), size=(101mm, Sub_W, Cop_H))
  GND4 [copper] = box(corner=(-Sub_L_phase_shift, -Sub_W/2, Sub_H+Cop_H*2+Bond_H+Sub_H), size=(101mm, Sub_W, Cop_H))
  Stem_wall_1 = cylinder(axis=Z, base_centre=(0mm, -Sub_W/2+10mm+(Array_d-SIW_W)/2, 0mm), radius=SIW_R, height=Sub_H+Cop_H+Bond_H+Sub_H+Cop_H)
  Stem1_1..Stem1_24 = Stem_wall_1.duplicate_along_line(step=(-SIW_D, 0mm, 0mm), total=25)
  Stem_wall_1.unite(Stem1_1..Stem1_24)
  Stem1_25 = Stem_wall_1.duplicate_along_line(step=(0mm, SIW_W, 0mm), total=2)
  Stem_wall_1.unite(Stem1_25)
  Stem_terminal_1 = cylinder(axis=Z, base_centre=(-num*SIW_D, -Sub_W/2+10mm+(Array_d-SIW_W)/2+SIW_D, 0mm), radius=SIW_R, height=Sub_H+Cop_H+Bond_H+Sub_H+Cop_H)
  Stem_2_1..Stem_2_6 = Stem_terminal_1.duplicate_along_line(step=(0mm, SIW_D, 0mm), total=7)
  Stem_terminal_1.unite(Stem_2_1..Stem_2_6)
  match_phase_shift_1 = cylinder(axis=Z, base_centre=(-num*SIW_D+match_x, -Sub_W/2+10mm+(Array_d-SIW_W)/2+match_y, 0mm), radius=SIW_R, height=Sub_H*2+Cop_H*2+Bond_H)
  slot1_1 = box(corner=(-num*SIW_D+slot_x, -Sub_W/2+10mm+(Array_d-SIW_W)/2+SIW_W-slot_y, Sub_H), size=(slot_length, -slot_width, Cop_H))
  slot2_1 = box(corner=(-num*SIW_D+slot_x, -Sub_W/2+10mm+(Array_d-SIW_W)/2+SIW_W-slot_y, Sub_H+Cop_H+Bond_H), size=(slot_length, -slot_width, Cop_H))
  Stem_terminal_13..Stem_terminal_20 [copper] = Stem_terminal_1.duplicate_along_line(step=(0mm, Array_d, 0mm), total=32)  # copies kept: 12..19
  Stem_wall_13..Stem_wall_20 = Stem_wall_1.duplicate_along_line(step=(0mm, Array_d, 0mm), total=32)  # copies kept: 12..19
  Stem_wall_1.delete()
  slot1_13..slot1_20 = slot1_1.duplicate_along_line(step=(0mm, Array_d, 0mm), total=32)  # copies kept: 12..19
  slot2_13..slot2_20 = slot2_1.duplicate_along_line(step=(0mm, Array_d, 0mm), total=32)  # copies kept: 12..19
  match_phase_shift_13..match_phase_shift_20 [copper] = match_phase_shift_1.duplicate_along_line(step=(0mm, Array_d, 0mm), total=32)  # copies kept: 12..19
  Stem_terminal_1.move(delay_length_1, 0mm, 0mm)
  Stem_terminal_1.delete()
  match_phase_shift_1.move(delay_length_1, 0mm, 0mm)
  match_phase_shift_1.delete()
  [slot1_1, slot2_1].move(delay_length_1, 0mm, 0mm)
  [slot1_1, slot2_1].delete()
  [Stem_terminal_13, match_phase_shift_13, slot1_13, slot2_13].move(delay_length_13, 0mm, 0mm)
  slot1_13_1 = slot1_13.copy()
  GND2.subtract(slot1_13_1)
  slot2_13_1 = slot2_13.copy()
  GND3.subtract(slot2_13_1)
  [Stem_terminal_14, match_phase_shift_14, slot1_14, slot2_14].move(delay_length_14, 0mm, 0mm)
  slot1_14_1 = slot1_14.copy()
  GND2.subtract(slot1_14_1)
  slot2_14_1 = slot2_14.copy()
  GND3.subtract(slot2_14_1)
  [Stem_terminal_15, match_phase_shift_15, slot1_15, slot2_15].move(delay_length_15, 0mm, 0mm)
  slot1_15_1 = slot1_15.copy()
  GND2.subtract(slot1_15_1)
  slot2_15_1 = slot2_15.copy()
  GND3.subtract(slot2_15_1)
  [Stem_terminal_16, match_phase_shift_16, slot1_16, slot2_16].move(delay_length_16, 0mm, 0mm)
  slot1_16_1 = slot1_16.copy()
  GND2.subtract(slot1_16_1)
  slot2_16_1 = slot2_16.copy()
  GND3.subtract(slot2_16_1)
  [Stem_terminal_17, match_phase_shift_17, slot1_17, slot2_17].move(delay_length_17, 0mm, 0mm)
  slot1_17_1 = slot1_17.copy()
  GND2.subtract(slot1_17_1)
  slot2_17_1 = slot2_17.copy()
  GND3.subtract(slot2_17_1)
  [Stem_terminal_18, match_phase_shift_18, slot1_18, slot2_18].move(delay_length_18, 0mm, 0mm)
  slot1_18_1 = slot1_18.copy()
  GND2.subtract(slot1_18_1)
  slot2_18_1 = slot2_18.copy()
  GND3.subtract(slot2_18_1)
  [Stem_terminal_19, match_phase_shift_19, slot1_19, slot2_19].move(delay_length_19, 0mm, 0mm)
  slot1_19_1 = slot1_19.copy()
  GND2.subtract(slot1_19_1)
  slot2_19_1 = slot2_19.copy()
  GND3.subtract(slot2_19_1)
  [Stem_terminal_20, match_phase_shift_20, slot1_20, slot2_20].move(delay_length_20, 0mm, 0mm)
  slot1_20_1 = slot1_20.copy()
  GND2.subtract(slot1_20_1)
  slot2_20_1 = slot2_20.copy()
  GND3.subtract(slot2_20_1)
  coordinate_system RelativeCS-PD = origin=((3.6*9) mm, 0mm, 0mm) x=(1mm, 0mm, 0mm) y=(0mm, 1mm, 0mm)
  coordinate_system RelativeCS4-2 = origin=(-14.4mm, -Array_d*4, 0mm) x=(1mm, 0mm, 0mm) y=(0mm, 1mm, 0mm) in RelativeCS-PD
  match_A4_2 [copper] = cylinder(axis=Z, base_centre=(Ax4, Ay4_2, 0mm), radius=SIW_R, height=Sub_H) in RelativeCS4-2
  match_B4_2 [copper] = cylinder(axis=Z, base_centre=(SIW_W/2-Bx4, -Array_d/2-SIW_W/2+By4, 0mm), radius=SIW_R, height=Sub_H) in RelativeCS4-2
  match_B4_2.move(0mm, -(4-1)/2*Array_d, 0mm) in RelativeCS4-2
  match2_11 = match_B4_2.duplicate_mirror(point=(0mm, 0mm, 0mm), normal=(0mm, 1mm, 0mm)) in RelativeCS4-2
  match_B4_2.unite(match2_11)
  coordinate_system RelativeCS5-3 = origin=(-7.2mm, -2*Array_d, 0mm) x=(1mm, 0mm, 0mm) y=(0mm, 1mm, 0mm) in RelativeCS4-2
  match_A5_3 [copper] = cylinder(axis=Z, base_centre=(Ax5, Ay5_3, 0mm), radius=SIW_R, height=Sub_H) in RelativeCS5-3
  match_B5_3 [copper] = cylinder(axis=Z, base_centre=(SIW_W/2-Bx5, -Array_d/2-SIW_W/2+By5, 0mm), radius=SIW_R, height=Sub_H) in RelativeCS5-3
  match_B5_3.move(0mm, -(2-1)/2*Array_d, 0mm) in RelativeCS5-3
  match2_12 = match_B5_3.duplicate_mirror(point=(0mm, 0mm, 0mm), normal=(0mm, 1mm, 0mm)) in RelativeCS5-3
  match_B5_3.unite(match2_12)
  coordinate_system RelativeCS5-4 = origin=(-7.2mm, 2*Array_d, 0mm) x=(1mm, 0mm, 0mm) y=(0mm, 1mm, 0mm) in RelativeCS4-2
  match_A5_4 [copper] = cylinder(axis=Z, base_centre=(Ax5, Ay5_4, 0mm), radius=SIW_R, height=Sub_H) in RelativeCS5-4
  match_B5_4 [copper] = cylinder(axis=Z, base_centre=(SIW_W/2-Bx5, -Array_d/2-SIW_W/2+By5, 0mm), radius=SIW_R, height=Sub_H) in RelativeCS5-4
  match_B5_4.move(0mm, -(2-1)/2*Array_d, 0mm) in RelativeCS5-4
  match2_13 = match_B5_4.duplicate_mirror(point=(0mm, 0mm, 0mm), normal=(0mm, 1mm, 0mm)) in RelativeCS5-4
  match_B5_4.unite(match2_13)
  coordinate_system RelativeCS6-5 = origin=(-14.4mm, -3*Array_d, 0mm) x=(1mm, 0mm, 0mm) y=(0mm, 1mm, 0mm) in RelativeCS4-2
  match_A6_5 [copper] = cylinder(axis=Z, base_centre=(Ax6, Ay6_5, 0mm), radius=SIW_R, height=Sub_H) in RelativeCS6-5
  match_B6_5 [copper] = cylinder(axis=Z, base_centre=(SIW_W/2-Bx6, -Array_d/2-SIW_W/2+By6, 0mm), radius=SIW_R, height=Sub_H) in RelativeCS6-5
  match2_14 = match_B6_5.duplicate_mirror(point=(0mm, 0mm, 0mm), normal=(0mm, 1mm, 0mm)) in RelativeCS6-5
  match_B6_5.unite(match2_14)
  coordinate_system RelativeCS6-6 = origin=(-14.4mm, -Array_d, 0mm) x=(1mm, 0mm, 0mm) y=(0mm, 1mm, 0mm) in RelativeCS4-2
  match_A6_6 [copper] = cylinder(axis=Z, base_centre=(Ax6, Ay6_6, 0mm), radius=SIW_R, height=Sub_H) in RelativeCS6-6
  match_B6_6 [copper] = cylinder(axis=Z, base_centre=(SIW_W/2-Bx6, -Array_d/2-SIW_W/2+By6, 0mm), radius=SIW_R, height=Sub_H) in RelativeCS6-6
  match2_15 = match_B6_6.duplicate_mirror(point=(0mm, 0mm, 0mm), normal=(0mm, 1mm, 0mm)) in RelativeCS6-6
  match_B6_6.unite(match2_15)
  coordinate_system RelativeCS6-7 = origin=(-14.4mm, Array_d, 0mm) x=(1mm, 0mm, 0mm) y=(0mm, 1mm, 0mm) in RelativeCS4-2
  match_A6_7 [copper] = cylinder(axis=Z, base_centre=(Ax6, Ay6_7, 0mm), radius=SIW_R, height=Sub_H) in RelativeCS6-7
  match_B6_7 [copper] = cylinder(axis=Z, base_centre=(SIW_W/2-Bx6, -Array_d/2-SIW_W/2+By6, 0mm), radius=SIW_R, height=Sub_H) in RelativeCS6-7
  match2_16 = match_B6_7.duplicate_mirror(point=(0mm, 0mm, 0mm), normal=(0mm, 1mm, 0mm)) in RelativeCS6-7
  match_B6_7.unite(match2_16)
  coordinate_system RelativeCS6-8 = origin=(-14.4mm, 3*Array_d, 0mm) x=(1mm, 0mm, 0mm) y=(0mm, 1mm, 0mm) in RelativeCS4-2
  match_A6_8 [copper] = cylinder(axis=Z, base_centre=(Ax6, Ay6_8, 0mm), radius=SIW_R, height=Sub_H) in RelativeCS6-8
  match_B6_8 [copper] = cylinder(axis=Z, base_centre=(SIW_W/2-Bx6, -Array_d/2-SIW_W/2+By6, 0mm), radius=SIW_R, height=Sub_H) in RelativeCS6-8
  match2_17 = match_B6_8.duplicate_mirror(point=(0mm, 0mm, 0mm), normal=(0mm, 1mm, 0mm)) in RelativeCS6-8
  match_B6_8.unite(match2_17)
  Stem1_53 [copper] = cylinder(axis=Z, base_centre=(SIW_W/2, -SIW_W/2, 0mm), radius=SIW_R, height=Sub_H) in RelativeCS4-2
  Stem1_1_41, Stem1_1_42, Stem1_1_43 = Stem1_53.duplicate_along_line(step=(SIW_D, 0mm, 0mm), total=4) in RelativeCS4-2
  Stem1_53.unite(Stem1_1_41, Stem1_1_42, Stem1_1_43)
  gate31 = cylinder(axis=Z, base_centre=(8*SIW_D, -SIW_W/2, 0mm), radius=SIW_R, height=Sub_H) in RelativeCS4-2
  Stem1_53.unite(gate31)
  Stem1_56 = cylinder(axis=Z, base_centre=(-SIW_W/2, 0, 0mm), radius=SIW_R, height=Sub_H) in RelativeCS4-2
  Stem1_56.move(0mm, -(Array_d-SIW_W)/2, 0mm) in RelativeCS4-2
  Stem1_6_131..Stem1_6_141 = Stem1_56.duplicate_along_line(step=(0mm, -SIW_D2, 0mm), total=12) in RelativeCS4-2
  Stem1_56.unite(Stem1_6_131..Stem1_6_141)
  Stem1_57 = cylinder(axis=Z, base_centre=(SIW_W/2, -SIW_W/2, 0mm), radius=SIW_R, height=Sub_H) in RelativeCS4-2
  Stem1_5_155..Stem1_5_169 = Stem1_57.duplicate_along_line(step=(0mm, -SIW_D2, 0mm), total=16) in RelativeCS4-2
  Stem1_57.unite(Stem1_5_155, Stem1_5_156, Stem1_5_158, Stem1_5_157, Stem1_5_159..Stem1_5_165, Stem1_5_167, Stem1_5_166, Stem1_5_168, Stem1_5_169)
  Stem1_58 = cylinder(axis=Z, base_centre=(-SIW_W/2+SIW_D/3*2, 0, 0mm), radius=SIW_R, height=Sub_H) in RelativeCS4-2
  Stem1_55 = cylinder(axis=Z, base_centre=(-SIW_W/2, -Array_d/2+SIW_W/2, 0mm), radius=SIW_R, height=Sub_H) in RelativeCS4-2
  Stem1_3_31, Stem1_3_32, Stem1_3_33 = Stem1_55.duplicate_along_line(step=(-SIW_D, 0mm, 0mm), total=4) in RelativeCS4-2
  Stem1_55.unite(Stem1_3_31, Stem1_3_32, Stem1_3_33)
  gate33 = cylinder(axis=Z, base_centre=(-8*SIW_D, -Array_d/2+SIW_W/2, 0mm), radius=SIW_R, height=Sub_H) in RelativeCS4-2
  Stem1_55.unite(gate33)
  Stem1_55.move(0mm, -(4-1)/2*Array_d, 0mm) in RelativeCS4-2
  Stem1_54 = cylinder(axis=Z, base_centre=(SIW_W/2, -Array_d/2-SIW_W/2, 0mm), radius=SIW_R, height=Sub_H) in RelativeCS4-2
  Stem1_2_127..Stem1_2_137 = Stem1_54.duplicate_along_line(step=(-SIW_D, 0mm, 0mm), total=12) in RelativeCS4-2
  Stem1_2_127.unite(Stem1_2_128..Stem1_2_137)
  gate32 = cylinder(axis=Z, base_centre=(-8*SIW_D, -Array_d/2-SIW_W/2, 0mm), radius=SIW_R, height=Sub_H) in RelativeCS4-2
  Stem1_54.unite(Stem1_2_127, gate32)
  Stem1_54.move(0mm, -(4-1)/2*Array_d, 0mm) in RelativeCS4-2
  Stem1_53.unite(Stem1_56, Stem1_57, Stem1_58, Stem1_55, Stem1_54)
  Stem1_1_44 = Stem1_53.duplicate_mirror(point=(0mm, 0mm, 0mm), normal=(0mm, 1mm, 0mm)) in RelativeCS4-2
  Stem1_53.unite(Stem1_1_44)
  Sub11 = box(corner=(-3.6mm, -Sub_W/2, 0mm), size=(7.2mm, Sub_W, Sub_H)) in RelativeCS4-2
  Stem1_53.intersect(Sub11)
  Stem1_59 = cylinder(axis=Z, base_centre=(SIW_W/2, -SIW_W/2, 0mm), radius=SIW_R, height=Sub_H) in RelativeCS5-3
  Stem1_1_45, Stem1_1_46, Stem1_1_47 = Stem1_59.duplicate_along_line(step=(SIW_D, 0mm, 0mm), total=4) in RelativeCS5-3
  Stem1_59.unite(Stem1_1_45, Stem1_1_46, Stem1_1_47)
  gate34 = cylinder(axis=Z, base_centre=(8*SIW_D, -SIW_W/2, 0mm), radius=SIW_R, height=Sub_H) in RelativeCS5-3
  Stem1_59.unite(gate34)
  Stem1_62 = cylinder(axis=Z, base_centre=(-SIW_W/2, 0, 0mm), radius=SIW_R, height=Sub_H) in RelativeCS5-3
  Stem1_62.move(0mm, -(Array_d-SIW_W)/2, 0mm) in RelativeCS5-3
  Stem1_6_142, Stem1_6_143, Stem1_6_144 = Stem1_62.duplicate_along_line(step=(0mm, -SIW_D2, 0mm), total=4) in RelativeCS5-3
  Stem1_62.unite(Stem1_6_142, Stem1_6_143, Stem1_6_144)
  Stem1_63 = cylinder(axis=Z, base_centre=(SIW_W/2, -SIW_W/2, 0mm), radius=SIW_R, height=Sub_H) in RelativeCS5-3
  Stem1_5_170..Stem1_5_176 = Stem1_63.duplicate_along_line(step=(0mm, -SIW_D2, 0mm), total=8) in RelativeCS5-3
  Stem1_63.unite(Stem1_5_170, Stem1_5_172, Stem1_5_171, Stem1_5_173..Stem1_5_176)
  Stem1_64 = cylinder(axis=Z, base_centre=(-SIW_W/2+SIW_D/3*2, 0, 0mm), radius=SIW_R, height=Sub_H) in RelativeCS5-3
  Stem1_61 = cylinder(axis=Z, base_centre=(-SIW_W/2, -Array_d/2+SIW_W/2, 0mm), radius=SIW_R, height=Sub_H) in RelativeCS5-3
  Stem1_3_34, Stem1_3_35, Stem1_3_36 = Stem1_61.duplicate_along_line(step=(-SIW_D, 0mm, 0mm), total=4) in RelativeCS5-3
  Stem1_61.unite(Stem1_3_34, Stem1_3_35, Stem1_3_36)
  gate36 = cylinder(axis=Z, base_centre=(-8*SIW_D, -Array_d/2+SIW_W/2, 0mm), radius=SIW_R, height=Sub_H) in RelativeCS5-3
  Stem1_61.unite(gate36)
  Stem1_61.move(0mm, -(2-1)/2*Array_d, 0mm) in RelativeCS5-3
  Stem1_60 = cylinder(axis=Z, base_centre=(SIW_W/2, -Array_d/2-SIW_W/2, 0mm), radius=SIW_R, height=Sub_H) in RelativeCS5-3
  Stem1_2_138..Stem1_2_148 = Stem1_60.duplicate_along_line(step=(-SIW_D, 0mm, 0mm), total=12) in RelativeCS5-3
  Stem1_2_138.unite(Stem1_2_139..Stem1_2_148)
  gate35 = cylinder(axis=Z, base_centre=(-8*SIW_D, -Array_d/2-SIW_W/2, 0mm), radius=SIW_R, height=Sub_H) in RelativeCS5-3
  Stem1_60.unite(Stem1_2_138, gate35)
  Stem1_60.move(0mm, -(2-1)/2*Array_d, 0mm) in RelativeCS5-3
  Stem1_59.unite(Stem1_62, Stem1_63, Stem1_64, Stem1_61, Stem1_60)
  Stem1_1_48 = Stem1_59.duplicate_mirror(point=(0mm, 0mm, 0mm), normal=(0mm, 1mm, 0mm)) in RelativeCS5-3
  Stem1_59.unite(Stem1_1_48)
  Sub12 = box(corner=(-3.6mm, -Sub_W/2, 0mm), size=(7.2mm, Sub_W, Sub_H)) in RelativeCS5-3
  Stem1_59.intersect(Sub12)
  Stem1_65 = cylinder(axis=Z, base_centre=(SIW_W/2, -SIW_W/2, 0mm), radius=SIW_R, height=Sub_H) in RelativeCS5-4
  Stem1_1_49, Stem1_1_50, Stem1_1_51 = Stem1_65.duplicate_along_line(step=(SIW_D, 0mm, 0mm), total=4) in RelativeCS5-4
  Stem1_65.unite(Stem1_1_49, Stem1_1_50, Stem1_1_51)
  gate37 = cylinder(axis=Z, base_centre=(8*SIW_D, -SIW_W/2, 0mm), radius=SIW_R, height=Sub_H) in RelativeCS5-4
  Stem1_65.unite(gate37)
  Stem1_68 = cylinder(axis=Z, base_centre=(-SIW_W/2, 0, 0mm), radius=SIW_R, height=Sub_H) in RelativeCS5-4
  Stem1_68.move(0mm, -(Array_d-SIW_W)/2, 0mm) in RelativeCS5-4
  Stem1_6_145, Stem1_6_146, Stem1_6_147 = Stem1_68.duplicate_along_line(step=(0mm, -SIW_D2, 0mm), total=4) in RelativeCS5-4
  Stem1_68.unite(Stem1_6_145, Stem1_6_146, Stem1_6_147)
  Stem1_69 = cylinder(axis=Z, base_centre=(SIW_W/2, -SIW_W/2, 0mm), radius=SIW_R, height=Sub_H) in RelativeCS5-4
  Stem1_5_177..Stem1_5_183 = Stem1_69.duplicate_along_line(step=(0mm, -SIW_D2, 0mm), total=8) in RelativeCS5-4
  Stem1_69.unite(Stem1_5_177, Stem1_5_179, Stem1_5_178, Stem1_5_180..Stem1_5_183)
  Stem1_70 = cylinder(axis=Z, base_centre=(-SIW_W/2+SIW_D/3*2, 0, 0mm), radius=SIW_R, height=Sub_H) in RelativeCS5-4
  Stem1_67 = cylinder(axis=Z, base_centre=(-SIW_W/2, -Array_d/2+SIW_W/2, 0mm), radius=SIW_R, height=Sub_H) in RelativeCS5-4
  Stem1_3_37, Stem1_3_38, Stem1_3_39 = Stem1_67.duplicate_along_line(step=(-SIW_D, 0mm, 0mm), total=4) in RelativeCS5-4
  Stem1_67.unite(Stem1_3_37, Stem1_3_38, Stem1_3_39)
  gate39 = cylinder(axis=Z, base_centre=(-8*SIW_D, -Array_d/2+SIW_W/2, 0mm), radius=SIW_R, height=Sub_H) in RelativeCS5-4
  Stem1_67.unite(gate39)
  Stem1_67.move(0mm, -(2-1)/2*Array_d, 0mm) in RelativeCS5-4
  Stem1_66 = cylinder(axis=Z, base_centre=(SIW_W/2, -Array_d/2-SIW_W/2, 0mm), radius=SIW_R, height=Sub_H) in RelativeCS5-4
  Stem1_2_149..Stem1_2_159 = Stem1_66.duplicate_along_line(step=(-SIW_D, 0mm, 0mm), total=12) in RelativeCS5-4
  Stem1_2_149.unite(Stem1_2_150..Stem1_2_159)
  gate38 = cylinder(axis=Z, base_centre=(-8*SIW_D, -Array_d/2-SIW_W/2, 0mm), radius=SIW_R, height=Sub_H) in RelativeCS5-4
  Stem1_66.unite(Stem1_2_149, gate38)
  Stem1_66.move(0mm, -(2-1)/2*Array_d, 0mm) in RelativeCS5-4
  Stem1_65.unite(Stem1_68, Stem1_69, Stem1_70, Stem1_67, Stem1_66)
  Stem1_1_52 = Stem1_65.duplicate_mirror(point=(0mm, 0mm, 0mm), normal=(0mm, 1mm, 0mm)) in RelativeCS5-4
  Stem1_65.unite(Stem1_1_52)
  Sub13 = box(corner=(-3.6mm, -Sub_W/2, 0mm), size=(7.2mm, Sub_W, Sub_H)) in RelativeCS5-4
  Stem1_65.intersect(Sub13)
  Stem1_71 = cylinder(axis=Z, base_centre=(SIW_W/2, -SIW_W/2, 0mm), radius=SIW_R, height=Sub_H) in RelativeCS6-5
  Stem1_1_53, Stem1_1_54, Stem1_1_55 = Stem1_71.duplicate_along_line(step=(SIW_D, 0mm, 0mm), total=4) in RelativeCS6-5
  Stem1_71.unite(Stem1_1_53, Stem1_1_54, Stem1_1_55)
  Stem1_74 = cylinder(axis=Z, base_centre=(-SIW_W/2+SIW_D/3*2, 0, 0mm), radius=SIW_R, height=Sub_H) in RelativeCS6-5
  Stem1_73 = cylinder(axis=Z, base_centre=(-SIW_W/2, -Array_d/2+SIW_W/2, 0mm), radius=SIW_R, height=Sub_H) in RelativeCS6-5
  Stem1_3_40, Stem1_3_41, Stem1_3_42 = Stem1_73.duplicate_along_line(step=(-SIW_D, 0mm, 0mm), total=4) in RelativeCS6-5
  Stem1_73.unite(Stem1_3_40, Stem1_3_41, Stem1_3_42)
  Stem1_72 = cylinder(axis=Z, base_centre=(SIW_W/2, -Array_d/2-SIW_W/2, 0mm), radius=SIW_R, height=Sub_H) in RelativeCS6-5
  Stem1_2_160..Stem1_2_170 = Stem1_72.duplicate_along_line(step=(-SIW_D, 0mm, 0mm), total=12) in RelativeCS6-5
  Stem1_2_171, Stem1_2_172, Stem1_2_173 = Stem1_72.duplicate_along_line(step=(0mm, SIW_D2, 0mm), total=4) in RelativeCS6-5
  Stem1_2_160.unite(Stem1_2_161, Stem1_2_162, Stem1_2_163, Stem1_2_165, Stem1_2_164, Stem1_2_166..Stem1_2_170)
  Stem1_2_171.unite(Stem1_2_172, Stem1_2_173)
  Stem1_72.unite(Stem1_2_160, Stem1_2_171)
  gate40 = cylinder(axis=Z, base_centre=(8*SIW_D, -SIW_W/2, 0mm), radius=SIW_R, height=Sub_H) in RelativeCS6-5
  gate41 = cylinder(axis=Z, base_centre=(-8*SIW_D, -Array_d/2-SIW_W/2, 0mm), radius=SIW_R, height=Sub_H) in RelativeCS6-5
  gate42 = cylinder(axis=Z, base_centre=(-8*SIW_D, -Array_d/2+SIW_W/2, 0mm), radius=SIW_R, height=Sub_H) in RelativeCS6-5
  gate40.unite(gate41, gate42)
  Sub14 = box(corner=(-3.6mm, -Sub_W, 0mm), size=(7.2mm, Sub_W*2, Sub_H)) in RelativeCS6-5
  gate40.intersect(Sub14)
  Stem1_71.unite(Stem1_74, Stem1_73, Stem1_72, gate40)
  Stem1_1_56 = Stem1_71.duplicate_mirror(point=(0, 0, 0), normal=(0mm, 1mm, 0mm)) in RelativeCS6-5
  Stem1_71.unite(Stem1_1_56)
  Stem1_75 = cylinder(axis=Z, base_centre=(SIW_W/2, -SIW_W/2, 0mm), radius=SIW_R, height=Sub_H) in RelativeCS6-6
  Stem1_1_57, Stem1_1_58, Stem1_1_59 = Stem1_75.duplicate_along_line(step=(SIW_D, 0mm, 0mm), total=4) in RelativeCS6-6
  Stem1_75.unite(Stem1_1_57, Stem1_1_58, Stem1_1_59)
  Stem1_78 = cylinder(axis=Z, base_centre=(-SIW_W/2+SIW_D/3*2, 0, 0mm), radius=SIW_R, height=Sub_H) in RelativeCS6-6
  Stem1_77 = cylinder(axis=Z, base_centre=(-SIW_W/2, -Array_d/2+SIW_W/2, 0mm), radius=SIW_R, height=Sub_H) in RelativeCS6-6
  Stem1_3_43, Stem1_3_44, Stem1_3_45 = Stem1_77.duplicate_along_line(step=(-SIW_D, 0mm, 0mm), total=4) in RelativeCS6-6
  Stem1_77.unite(Stem1_3_43, Stem1_3_44, Stem1_3_45)
  Stem1_76 = cylinder(axis=Z, base_centre=(SIW_W/2, -Array_d/2-SIW_W/2, 0mm), radius=SIW_R, height=Sub_H) in RelativeCS6-6
  Stem1_2_174..Stem1_2_184 = Stem1_76.duplicate_along_line(step=(-SIW_D, 0mm, 0mm), total=12) in RelativeCS6-6
  Stem1_2_185, Stem1_2_186, Stem1_2_187 = Stem1_76.duplicate_along_line(step=(0mm, SIW_D2, 0mm), total=4) in RelativeCS6-6
  Stem1_2_174.unite(Stem1_2_175, Stem1_2_176, Stem1_2_177, Stem1_2_179, Stem1_2_178, Stem1_2_180..Stem1_2_184)
  Stem1_2_185.unite(Stem1_2_186, Stem1_2_187)
  Stem1_76.unite(Stem1_2_174, Stem1_2_185)
  gate43 = cylinder(axis=Z, base_centre=(8*SIW_D, -SIW_W/2, 0mm), radius=SIW_R, height=Sub_H) in RelativeCS6-6
  gate44 = cylinder(axis=Z, base_centre=(-8*SIW_D, -Array_d/2-SIW_W/2, 0mm), radius=SIW_R, height=Sub_H) in RelativeCS6-6
  gate45 = cylinder(axis=Z, base_centre=(-8*SIW_D, -Array_d/2+SIW_W/2, 0mm), radius=SIW_R, height=Sub_H) in RelativeCS6-6
  gate43.unite(gate44, gate45)
  Sub15 = box(corner=(-3.6mm, -Sub_W, 0mm), size=(7.2mm, Sub_W*2, Sub_H)) in RelativeCS6-6
  gate43.intersect(Sub15)
  Stem1_75.unite(Stem1_78, Stem1_77, Stem1_76, gate43)
  Stem1_1_60 = Stem1_75.duplicate_mirror(point=(0, 0, 0), normal=(0mm, 1mm, 0mm)) in RelativeCS6-6
  Stem1_75.unite(Stem1_1_60)
  Stem1_79 = cylinder(axis=Z, base_centre=(SIW_W/2, -SIW_W/2, 0mm), radius=SIW_R, height=Sub_H) in RelativeCS6-7
  Stem1_1_61, Stem1_1_62, Stem1_1_63 = Stem1_79.duplicate_along_line(step=(SIW_D, 0mm, 0mm), total=4) in RelativeCS6-7
  Stem1_79.unite(Stem1_1_61, Stem1_1_62, Stem1_1_63)
  Stem1_82 = cylinder(axis=Z, base_centre=(-SIW_W/2+SIW_D/3*2, 0, 0mm), radius=SIW_R, height=Sub_H) in RelativeCS6-7
  Stem1_81 = cylinder(axis=Z, base_centre=(-SIW_W/2, -Array_d/2+SIW_W/2, 0mm), radius=SIW_R, height=Sub_H) in RelativeCS6-7
  Stem1_3_46, Stem1_3_47, Stem1_3_48 = Stem1_81.duplicate_along_line(step=(-SIW_D, 0mm, 0mm), total=4) in RelativeCS6-7
  Stem1_81.unite(Stem1_3_46, Stem1_3_47, Stem1_3_48)
  Stem1_80 = cylinder(axis=Z, base_centre=(SIW_W/2, -Array_d/2-SIW_W/2, 0mm), radius=SIW_R, height=Sub_H) in RelativeCS6-7
  Stem1_2_188..Stem1_2_198 = Stem1_80.duplicate_along_line(step=(-SIW_D, 0mm, 0mm), total=12) in RelativeCS6-7
  Stem1_2_199, Stem1_2_200, Stem1_2_201 = Stem1_80.duplicate_along_line(step=(0mm, SIW_D2, 0mm), total=4) in RelativeCS6-7
  Stem1_2_188.unite(Stem1_2_189, Stem1_2_190, Stem1_2_191, Stem1_2_193, Stem1_2_192, Stem1_2_194..Stem1_2_198)
  Stem1_2_199.unite(Stem1_2_200, Stem1_2_201)
  Stem1_80.unite(Stem1_2_188, Stem1_2_199)
  gate46 = cylinder(axis=Z, base_centre=(8*SIW_D, -SIW_W/2, 0mm), radius=SIW_R, height=Sub_H) in RelativeCS6-7
  gate47 = cylinder(axis=Z, base_centre=(-8*SIW_D, -Array_d/2-SIW_W/2, 0mm), radius=SIW_R, height=Sub_H) in RelativeCS6-7
  gate48 = cylinder(axis=Z, base_centre=(-8*SIW_D, -Array_d/2+SIW_W/2, 0mm), radius=SIW_R, height=Sub_H) in RelativeCS6-7
  gate46.unite(gate47, gate48)
  Sub16 = box(corner=(-3.6mm, -Sub_W, 0mm), size=(7.2mm, Sub_W*2, Sub_H)) in RelativeCS6-7
  gate46.intersect(Sub16)
  Stem1_79.unite(Stem1_82, Stem1_81, Stem1_80, gate46)
  Stem1_1_64 = Stem1_79.duplicate_mirror(point=(0, 0, 0), normal=(0mm, 1mm, 0mm)) in RelativeCS6-7
  Stem1_79.unite(Stem1_1_64)
  Stem1_83 = cylinder(axis=Z, base_centre=(SIW_W/2, -SIW_W/2, 0mm), radius=SIW_R, height=Sub_H) in RelativeCS6-8
  Stem1_1_65, Stem1_1_66, Stem1_1_67 = Stem1_83.duplicate_along_line(step=(SIW_D, 0mm, 0mm), total=4) in RelativeCS6-8
  Stem1_83.unite(Stem1_1_65, Stem1_1_66, Stem1_1_67)
  Stem1_86 = cylinder(axis=Z, base_centre=(-SIW_W/2+SIW_D/3*2, 0, 0mm), radius=SIW_R, height=Sub_H) in RelativeCS6-8
  Stem1_85 = cylinder(axis=Z, base_centre=(-SIW_W/2, -Array_d/2+SIW_W/2, 0mm), radius=SIW_R, height=Sub_H) in RelativeCS6-8
  Stem1_3_49, Stem1_3_50, Stem1_3_51 = Stem1_85.duplicate_along_line(step=(-SIW_D, 0mm, 0mm), total=4) in RelativeCS6-8
  Stem1_85.unite(Stem1_3_49, Stem1_3_50, Stem1_3_51)
  Stem1_84 = cylinder(axis=Z, base_centre=(SIW_W/2, -Array_d/2-SIW_W/2, 0mm), radius=SIW_R, height=Sub_H) in RelativeCS6-8
  Stem1_2_202..Stem1_2_212 = Stem1_84.duplicate_along_line(step=(-SIW_D, 0mm, 0mm), total=12) in RelativeCS6-8
  Stem1_2_213, Stem1_2_214, Stem1_2_215 = Stem1_84.duplicate_along_line(step=(0mm, SIW_D2, 0mm), total=4) in RelativeCS6-8
  Stem1_2_202.unite(Stem1_2_203, Stem1_2_204, Stem1_2_205, Stem1_2_207, Stem1_2_206, Stem1_2_208..Stem1_2_212)
  Stem1_2_213.unite(Stem1_2_214, Stem1_2_215)
  Stem1_84.unite(Stem1_2_202, Stem1_2_213)
  gate49 = cylinder(axis=Z, base_centre=(8*SIW_D, -SIW_W/2, 0mm), radius=SIW_R, height=Sub_H) in RelativeCS6-8
  gate50 = cylinder(axis=Z, base_centre=(-8*SIW_D, -Array_d/2-SIW_W/2, 0mm), radius=SIW_R, height=Sub_H) in RelativeCS6-8
  gate51 = cylinder(axis=Z, base_centre=(-8*SIW_D, -Array_d/2+SIW_W/2, 0mm), radius=SIW_R, height=Sub_H) in RelativeCS6-8
  gate49.unite(gate50, gate51)
  Sub17 = box(corner=(-3.6mm, -Sub_W, 0mm), size=(7.2mm, Sub_W*2, Sub_H)) in RelativeCS6-8
  gate49.intersect(Sub17)
  Stem1_83.unite(Stem1_86, Stem1_85, Stem1_84, gate49)
  Stem1_1_68 = Stem1_83.duplicate_mirror(point=(0, 0, 0), normal=(0mm, 1mm, 0mm)) in RelativeCS6-8
  Stem1_83.unite(Stem1_1_68)
  Stem1_53.unite(Stem1_59, Stem1_65, Stem1_71, Stem1_75, Stem1_79, Stem1_83)
  coordinate_system RelativeCS3-1 = origin=(-7.2mm, -Array_d*8, 0mm) x=(1mm, 0mm, 0mm) y=(0mm, 1mm, 0mm) in RelativeCS-PD
  coordinate_system RelativeCS3-2 = origin=(-7.2mm, Array_d*8, 0mm) x=(1mm, 0mm, 0mm) y=(0mm, 1mm, 0mm) in RelativeCS-PD
  coordinate_system RelativeCS4-1 = origin=(-14.4mm, -Array_d*12, 0mm) x=(1mm, 0mm, 0mm) y=(0mm, 1mm, 0mm) in RelativeCS-PD
  coordinate_system RelativeCS4-3 = origin=(-14.4mm, Array_d*4, 0mm) x=(1mm, 0mm, 0mm) y=(0mm, 1mm, 0mm) in RelativeCS-PD
  coordinate_system RelativeCS4-4 = origin=(-14.4mm, Array_d*12, 0mm) x=(1mm, 0mm, 0mm) y=(0mm, 1mm, 0mm) in RelativeCS-PD
  coordinate_system RelativeCS5-1 = origin=(-7.2mm, -2*Array_d, 0mm) x=(1mm, 0mm, 0mm) y=(0mm, 1mm, 0mm) in RelativeCS4-1
  coordinate_system RelativeCS5-2 = origin=(-7.2mm, 2*Array_d, 0mm) x=(1mm, 0mm, 0mm) y=(0mm, 1mm, 0mm) in RelativeCS4-1
  coordinate_system RelativeCS6-1 = origin=(-14.4mm, -3*Array_d, 0mm) x=(1mm, 0mm, 0mm) y=(0mm, 1mm, 0mm) in RelativeCS4-1
  coordinate_system RelativeCS6-2 = origin=(-14.4mm, -Array_d, 0mm) x=(1mm, 0mm, 0mm) y=(0mm, 1mm, 0mm) in RelativeCS4-1
  coordinate_system RelativeCS6-3 = origin=(-14.4mm, Array_d, 0mm) x=(1mm, 0mm, 0mm) y=(0mm, 1mm, 0mm) in RelativeCS4-1
  coordinate_system RelativeCS6-4 = origin=(-14.4mm, 3*Array_d, 0mm) x=(1mm, 0mm, 0mm) y=(0mm, 1mm, 0mm) in RelativeCS4-1
  coordinate_system RelativeCS5-5 = origin=(-7.2mm, -2*Array_d, 0mm) x=(1mm, 0mm, 0mm) y=(0mm, 1mm, 0mm) in RelativeCS4-3
  coordinate_system RelativeCS5-6 = origin=(-7.2mm, 2*Array_d, 0mm) x=(1mm, 0mm, 0mm) y=(0mm, 1mm, 0mm) in RelativeCS4-3
  coordinate_system RelativeCS6-9 = origin=(-14.4mm, -3*Array_d, 0mm) x=(1mm, 0mm, 0mm) y=(0mm, 1mm, 0mm) in RelativeCS4-3
  coordinate_system RelativeCS6-10 = origin=(-14.4mm, -Array_d, 0mm) x=(1mm, 0mm, 0mm) y=(0mm, 1mm, 0mm) in RelativeCS4-3
  coordinate_system RelativeCS6-11 = origin=(-14.4mm, Array_d, 0mm) x=(1mm, 0mm, 0mm) y=(0mm, 1mm, 0mm) in RelativeCS4-3
  coordinate_system RelativeCS6-12 = origin=(-14.4mm, 3*Array_d, 0mm) x=(1mm, 0mm, 0mm) y=(0mm, 1mm, 0mm) in RelativeCS4-3
  coordinate_system RelativeCS5-7 = origin=(-7.2mm, -2*Array_d, 0mm) x=(1mm, 0mm, 0mm) y=(0mm, 1mm, 0mm) in RelativeCS4-4
  coordinate_system RelativeCS5-8 = origin=(-7.2mm, 2*Array_d, 0mm) x=(1mm, 0mm, 0mm) y=(0mm, 1mm, 0mm) in RelativeCS4-4
  coordinate_system RelativeCS6-13 = origin=(-14.4mm, -3*Array_d, 0mm) x=(1mm, 0mm, 0mm) y=(0mm, 1mm, 0mm) in RelativeCS4-4
  coordinate_system RelativeCS6-14 = origin=(-14.4mm, -Array_d, 0mm) x=(1mm, 0mm, 0mm) y=(0mm, 1mm, 0mm) in RelativeCS4-4
  coordinate_system RelativeCS6-15 = origin=(-14.4mm, Array_d, 0mm) x=(1mm, 0mm, 0mm) y=(0mm, 1mm, 0mm) in RelativeCS4-4
  coordinate_system RelativeCS6-16 = origin=(-14.4mm, 3*Array_d, 0mm) x=(1mm, 0mm, 0mm) y=(0mm, 1mm, 0mm) in RelativeCS4-4
  coordinate_system RelativeCS-Slot = origin=(30mm, 0mm, Cop_H*2+Bond_H+Sub_H) x=(-1mm, 0mm, 0mm) y=(0mm, -1mm, 0mm)
  coordinate_system RelativeCS-Center = origin=(-2.4mm, 0mm, 0mm) x=(1mm, 0mm, 0mm) y=(0mm, 1mm, 0mm) in RelativeCS-PD
  coordinate_system RelativeCS-Trans = origin=(55mm-8.6mm, 0mm, 0mm) x=(1mm, 0mm, 0mm) y=(0mm, 1mm, 0mm) in RelativeCS-Center
  ELC_Screw_1 = cylinder(axis=Z, base_centre=(4.765mm, ELC_Sub_L-2.79mm, -4mm), radius=1mm, height=4mm+4.8006mm+ELC_Sub_H) in RelativeCS-Trans
  ELC_Screw_1.rotate(axis=Z, angle=-90deg) in RelativeCS-Trans
  ELC_Screw_1.move(-3.9mm, 0mm, 0mm) in RelativeCS-Trans
  ELC_Screw_1.move(0mm, 0mm, -0.018mm) in RelativeCS-Trans
  ELC_Screw_1.move(2.5mm, 0mm, 0mm) in RelativeCS-Trans
  ELC_Screw_1.mirror(point=(0, 0, 0), normal=(0mm, 0mm, -1mm)) in RelativeCS-Trans
  ELC_Screw_1.move(0mm, 0mm, 0.508mm) in RelativeCS-Trans
  ELC_Screw_2 = cylinder(axis=Z, base_centre=(-4.765mm, ELC_Sub_L-2.79mm, -4mm), radius=1mm, height=4mm+4.8006mm+ELC_Sub_H) in RelativeCS-Trans
  ELC_Screw_2.rotate(axis=Z, angle=-90deg) in RelativeCS-Trans
  ELC_Screw_2.move(-3.9mm, 0mm, 0mm) in RelativeCS-Trans
  ELC_Screw_2.move(0mm, 0mm, -0.018mm) in RelativeCS-Trans
  ELC_Screw_2.move(2.5mm, 0mm, 0mm) in RelativeCS-Trans
  ELC_Screw_2.mirror(point=(0, 0, 0), normal=(0mm, 0mm, -1mm)) in RelativeCS-Trans
  ELC_Screw_2.move(0mm, 0mm, 0.508mm) in RelativeCS-Trans
  [ELC_Screw_1, ELC_Screw_2].move(-9mm, 0mm, 0.795mm)
  trans1 = box(corner=(0.5mm, -Trans_W/2-Trans_slotL, 0), size=(Trans_slotw, Trans_slotL, -Cop_H)) in RelativeCS-Trans
  trans1_1 = trans1.duplicate_mirror(point=(0, 0, 0), normal=(0mm, 1mm, 0mm)) in RelativeCS-Trans
  trans1.unite(trans1_1)
  trans2 = box(corner=(0.5mm+Trans_L, -Feed_W/2-gapw, 0), size=(Feed_L, gapw, -Cop_H)) in RelativeCS-Trans
  trans1_2 = trans2.duplicate_mirror(point=(0, 0, 0), normal=(0mm, 1mm, 0mm)) in RelativeCS-Trans
  trans2.unite(trans1_2)
  Polyline1 = polyline(z=0mm, xy: (0.5mm, -Trans_W/2) (0.5mm, -Trans_W2/2) (0.5mm+Trans_L, -Feed_W/2-gapw) (0.5mm+Trans_L, -Feed_W/2) (0.5mm, -Trans_W/2), covered) in RelativeCS-Trans
  Polyline1.sweep_along_vector((0mm, 0mm, -Cop_H)) in RelativeCS-Trans
  Polyline1_1 = Polyline1.duplicate_mirror(point=(0mm, 0mm, 0mm), normal=(0mm, 1mm, 0mm)) in RelativeCS-Trans
  Polyline1.unite(Polyline1_1)
  trans1.unite(trans2, Polyline1)
  ELC_Screw_1_3 = ELC_Screw_1.copy()
  ELC_Screw_2_3 = ELC_Screw_2.copy()
  GND1.subtract(ELC_Screw_1_3, ELC_Screw_2_3)
  ELC_Screw_1_4 = ELC_Screw_1.copy()
  ELC_Screw_2_4 = ELC_Screw_2.copy()
  GND2.subtract(ELC_Screw_1_4, ELC_Screw_2_4)
  ELC_Screw_1_5 = ELC_Screw_1.copy()
  ELC_Screw_2_5 = ELC_Screw_2.copy()
  GND3.subtract(ELC_Screw_1_5, ELC_Screw_2_5)
  ELC_Screw_1_6 = ELC_Screw_1.copy()
  ELC_Screw_1.delete()
  ELC_Screw_2_6 = ELC_Screw_2.copy()
  ELC_Screw_2.delete()
  trans1.move(-9mm, 0mm, 0mm) in RelativeCS-Center
  GND1.subtract(trans1)
  Box7 = box(corner=(-65mm, 20mm, -10mm), size=(120mm, 70mm, 20mm)) in RelativeCS-Center
  Box7_1 = Box7.duplicate_mirror(point=(0mm, 0mm, 0mm), normal=(0mm, -1mm, 0mm)) in RelativeCS-Center
  Box7_2 = Box7.copy()
  Box7_1_1 = Box7_1.copy()
  Bond_layer.subtract(Box7_2, Box7_1_1)
  Box7_3 = Box7.copy()
  Box7_1_2 = Box7_1.copy()
  GND1.subtract(Box7_3, Box7_1_2)
  Box7_4 = Box7.copy()
  Box7_1_3 = Box7_1.copy()
  GND2.subtract(Box7_4, Box7_1_3)
  Box7_5 = Box7.copy()
  Box7_1_4 = Box7_1.copy()
  GND3.subtract(Box7_5, Box7_1_4)
  Box7_6 = Box7.copy()
  Box7_1_5 = Box7_1.copy()
  GND4.subtract(Box7_6, Box7_1_5)
  Box7_7 = Box7.copy()
  Box7_1_6 = Box7_1.copy()
  Sub.subtract(Box7_7, Box7_1_6)
  Sub1.subtract(Box7, Box7_1)
  Box8 = box(corner=(-65mm, -50mm, -10mm), size=(20mm, 95mm, 20mm)) in RelativeCS-Center
  Box8_1 = Box8.copy()
  Bond_layer.subtract(Box8_1)
  Box8_2 = Box8.copy()
  GND1.subtract(Box8_2)
  Box8_3 = Box8.copy()
  GND2.subtract(Box8_3)
  Box8_4 = Box8.copy()
  GND3.subtract(Box8_4)
  Box8_5 = Box8.copy()
  GND4.subtract(Box8_5)
  Box8_6 = Box8.copy()
  Sub.subtract(Box8_6)
  Sub1.subtract(Box8)
  ELC_Screw_1_6_1 = ELC_Screw_1_6.copy()
  ELC_Screw_2_6_1 = ELC_Screw_2_6.copy()
  Bond_layer.subtract(ELC_Screw_1_6_1, ELC_Screw_2_6_1)
  ELC_Screw_1_6_2 = ELC_Screw_1_6.copy()
  ELC_Screw_2_6_2 = ELC_Screw_2_6.copy()
  GND1.subtract(ELC_Screw_1_6_2, ELC_Screw_2_6_2)
  ELC_Screw_1_6_3 = ELC_Screw_1_6.copy()
  ELC_Screw_2_6_3 = ELC_Screw_2_6.copy()
  GND2.subtract(ELC_Screw_1_6_3, ELC_Screw_2_6_3)
  ELC_Screw_1_6_4 = ELC_Screw_1_6.copy()
  ELC_Screw_2_6_4 = ELC_Screw_2_6.copy()
  GND3.subtract(ELC_Screw_1_6_4, ELC_Screw_2_6_4)
  ELC_Screw_1_6_5 = ELC_Screw_1_6.copy()
  ELC_Screw_2_6_5 = ELC_Screw_2_6.copy()
  GND4.subtract(ELC_Screw_1_6_5, ELC_Screw_2_6_5)
  ELC_Screw_1_6_6 = ELC_Screw_1_6.copy()
  ELC_Screw_2_6_6 = ELC_Screw_2_6.copy()
  Sub.subtract(ELC_Screw_1_6_6, ELC_Screw_2_6_6)
  Sub1.subtract(ELC_Screw_1_6, ELC_Screw_2_6)
  Box9 = box(corner=(-29.8mm, -30mm, Sub_H+Cop_H+Bond_H), size=(75.8mm, 60mm, 32.6mm)) in RelativeCS-Center
  Box9_1 = Box9.copy()
  GND3.subtract(Box9_1)
  Box9_2 = Box9.copy()
  GND4.subtract(Box9_2)
  Sub1.subtract(Box9)
  [Stem1_53, match_B6_5, match_B6_8, match_B6_7].move(0mm, 17.2mm, 0mm) in RelativeCS-Center
  [match_B6_5, match_B6_6].move(0mm, (17.2/2) mm, 0mm) in RelativeCS-Center
  [match_A6_5..match_A6_8, match_B5_4, match_B5_3, match_A5_4, match_A5_3, match_A4_2, match_B4_2].move(0mm, 17.2mm, 0mm) in RelativeCS-Center
  GND2.subtract(slot1_13..slot1_20)
  GND3.subtract(slot2_13..slot2_20)
  Rectangle1 = rectangle(corner=(-29.8mm, -16.85mm, 1.286mm), y_size=3.61mm, z_size=-0.506mm) in RelativeCS-Center
  Rectangle2 = rectangle(corner=(-29.8mm, -12.55mm, 1.286mm), y_size=3.61mm, z_size=-0.506mm) in RelativeCS-Center
  Rectangle3 = rectangle(corner=(-29.8mm, -8.25mm, 1.286mm), y_size=3.61mm, z_size=-0.506mm) in RelativeCS-Center
  Rectangle4 = rectangle(corner=(-29.8mm, -3.95mm, 1.286mm), y_size=3.61mm, z_size=-0.508mm) in RelativeCS-Center
  Rectangle5 = rectangle(corner=(-29.8mm, 0.35mm, 1.286mm), y_size=3.61mm, z_size=-0.506mm) in RelativeCS-Center
  Rectangle6 = rectangle(corner=(-29.8mm, 4.65mm, 1.286mm), y_size=3.61mm, z_size=-0.506mm) in RelativeCS-Center
  Rectangle7 = rectangle(corner=(-29.8mm, 8.95mm, 1.286mm), y_size=3.61mm, z_size=-0.506mm) in RelativeCS-Center
  Rectangle8 = rectangle(corner=(-29.8mm, 13.25mm, 1.286mm), y_size=3.61mm, z_size=-0.506mm) in RelativeCS-Center
  Box10 [pec] = box(corner=(-29.8mm, -16.85mm, 1.286mm), size=(0.2mm, 3.61mm, -0.506mm)) in RelativeCS-Center
  Box11 [pec] = box(corner=(-29.8mm, -12.55mm, 1.286mm), size=(0.2mm, 3.61mm, -0.506mm)) in RelativeCS-Center
  Box12 [pec] = box(corner=(-29.8mm, -8.25mm, 1.286mm), size=(0.2mm, 3.61mm, -0.506mm)) in RelativeCS-Center
  Box13 [pec] = box(corner=(-29.8mm, -3.95mm, 1.286mm), size=(0.2mm, 3.61mm, -0.508mm)) in RelativeCS-Center
  Box14 [pec] = box(corner=(-29.8mm, 0.35mm, 1.286mm), size=(0.2mm, 3.61mm, -0.506mm)) in RelativeCS-Center
  Box15 [pec] = box(corner=(-29.8mm, 4.65mm, 1.286mm), size=(0.2mm, 3.61mm, -0.506mm)) in RelativeCS-Center
  Box16 [pec] = box(corner=(-29.8mm, 8.95mm, 1.286mm), size=(0.2mm, 3.61mm, -0.506mm)) in RelativeCS-Center
  Box17 [pec] = box(corner=(-29.8mm, 13.25mm, 1.286mm), size=(0.2mm, 3.61mm, -0.506mm)) in RelativeCS-Center
  Box18 = box(corner=(-8.4mm, -25mm, -10mm), size=(58mm, 50mm, 20mm)) in RelativeCS-Center
  Box18_1 = Box18.copy()
  Bond_layer.subtract(Box18_1)
  Box18_2 = Box18.copy()
  GND1.subtract(Box18_2)
  Box18_3 = Box18.copy()
  GND2.subtract(Box18_3)
  Box18_4 = Box18.copy()
  GND3.subtract(Box18_4)
  Box18_5 = Box18.copy()
  GND4.subtract(Box18_5)
  Box18_6 = Box18.copy()
  Sub.subtract(Box18_6)
  Sub1.subtract(Box18)
  Stem1_53.unite(Stem_wall_13..Stem_wall_20)
  Rectangle9 = rectangle(corner=(-8.4mm, -1.8mm, 0.508mm), y_size=3.6mm, z_size=-0.508mm) in RelativeCS-Center
  Box19 [pec] = box(corner=(-8.4mm, -1.8mm, 0.508mm), size=(0.2mm, 3.6mm, -0.508mm)) in RelativeCS-Center
  Box20 [vacuum] = box(corner=(-45mm, -20mm, -0.1mm), size=(37mm, 40mm, 1.6mm)) in RelativeCS-Center
boundaries and excitations:
  Rad1: Radiation Objects=Box20
  2: Wave Port Objects=Rectangle1 WavePortType=Modal NumModes=1 Modes{Mode1{IntLine{(0.2, -15.045, 0.78) -> (0.2, -15.05, 1.286)} CharImp=Zpi RenormImp=50ohm}}
  3: Wave Port Objects=Rectangle2 WavePortType=Modal NumModes=1 Modes{Mode1{IntLine{(0.2, -10.745, 0.78) -> (0.2, -10.75, 1.286)} CharImp=Zpi RenormImp=50ohm}}
  4: Wave Port Objects=Rectangle3 WavePortType=Modal NumModes=1 Modes{Mode1{IntLine{(0.2, -6.445, 0.78) -> (0.2, -6.445, 1.286)} CharImp=Zpi RenormImp=50ohm}}
  5: Wave Port Objects=Rectangle4 WavePortType=Modal NumModes=1 Modes{Mode1{IntLine{(0.2, -2.145, 0.778) -> (0.2, -2.145, 1.286)} CharImp=Zpi RenormImp=50ohm}}
  6: Wave Port Objects=Rectangle5 WavePortType=Modal NumModes=1 Modes{Mode1{IntLine{(0.2, 2.155, 0.78) -> (0.2, 2.15, 1.286)} CharImp=Zpi RenormImp=50ohm}}
  7: Wave Port Objects=Rectangle6 WavePortType=Modal NumModes=1 Modes{Mode1{IntLine{(0.2, 6.455, 0.78) -> (0.2, 6.45, 1.286)} CharImp=Zpi RenormImp=50ohm}}
  8: Wave Port Objects=Rectangle7 WavePortType=Modal NumModes=1 Modes{Mode1{IntLine{(0.2, 10.755, 0.78) -> (0.2, 10.75, 1.286)} CharImp=Zpi RenormImp=50ohm}}
  9: Wave Port Objects=Rectangle8 WavePortType=Modal NumModes=1 Modes{Mode1{IntLine{(0.2, 15.055, 0.78) -> (0.2, 15.05, 1.286)} CharImp=Zpi RenormImp=50ohm}}
  1: Wave Port Objects=Rectangle9 WavePortType=Modal NumModes=1 Modes{Mode1{IntLine{(21.6, 0, 0) -> (21.6, 0, 0.508)} CharImp=Zpi RenormImp=50ohm}}
setups:
  Setup1: HfssDriven Frequency=35GHz MaxDeltaS=0.02 MaximumPasses=10 MinimumPasses=1 MinimumConvergedPasses=1 PercentRefinement=20 BasisOrder=1 PortAccuracy=2 DrivenSolverType="Direct Solver"
source amplitudes:
  2:1: 1W 0deg
  3:1, 4:1, 5:1, 6:1, 7:1, 8:1, 9:1, 1:1: 0W 0deg
reports:
  S Parameter Plot 1: mag(S(2,1)), mag(S(3,1)), mag(S(4,1)), mag(S(5,1)), mag(S(6,1)), mag(S(7,1)), mag(S(8,1)), mag(S(9,1)), cang_deg(S(2,1)), cang_deg(S(3,1)), cang_deg(S(4,1)), cang_deg(S(5,1)), cang_deg(S(6,1)), cang_deg(S(7,1)), cang_deg(S(8,1)), cang_deg(S(9,1)) vs Freq on Setup1 : LastAdaptive
